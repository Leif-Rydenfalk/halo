* halo rev A sounder: 25 nF bender, 100 R series, anti-phase from two GPIO at 4.0 kHz, 2.0 V cell at 60 ohm
* why: mid-range, and the middle of research/05 §11.6's own 20-30 nF bracket
* PULSE(V1 V2 TD TR TF PW PER) on each pin, the second delayed by half a period, is anti-phase: when P1.11 is at VDD, P1.12 is at 0, so the bender sees +VDD, and half a cycle later -VDD. That is 2 x VDD peak to peak from a single rail and it is the whole reason D11a needs no boost converter.
* const   cp_F = 2.5e-08 F  [mid-range, and the middle of research/05 §11.6's own 20-30 nF bracket]
* const   rs_ohm = 500 ohm  [lane G's figure for the Murata 7BB-20-3, carried in ce-designs/halo/design.py: '3.6 kHz free resonance, 500 ohm'. THE DATASHEET WAS NEVER FETCHED - research/05 §11.7 records the part is in no catalogue that answers a machine.]
* const   r_drive_ohm = 40 ohm  [nRF54L GPIO output resistance in HIGH DRIVE. Nordic's standard drive is nearer 100 ohm; the high-drive figure is taken as 40 ohm. NOT FETCHED FROM THE DATASHEET - it is an estimate, and the peak current below is inversely proportional to it, so this is the largest uncertainty in this study.]
* const   vdd_V = 2 V  [end-of-life cell OCV — TI SWRA349's stated threshold. Driving from the WORST rail, not the nominal one.]
* const   f_drive_Hz = 4000 Hz  [near the Ø20 bender's free resonance, design.py: 3.6 kHz. The drive is a square wave because a GPIO has no other shape.]
* const   r9_ohm = 100 ohm  [R9 on the schematic: series damping on one leg, so a GPIO edge into a capacitive load is not an unlimited current spike off the bulk capacitors]
*
vcell vcell 0 DC 2
resr vcell vbat 60
cbulk vbat 0 4e-05
vp drv_p 0 PULSE(0 2 0 1e-06 1e-06 0.000124 0.00025)
vn drv_n 0 PULSE(2 0 0 1e-06 1e-06 0.000124 0.00025)
rdrvp drv_p pin_p 40
rdrvn drv_n pin_n 40
r9 pin_p bend_p 100
cbend bend_p bend_r 2.5e-08
rbendloss bend_r pin_n 500
.tran 6.25e-07 0.002 0 6.25e-07
.end
